* ============================================================
* SKY130 Two-Stage CMOS Operational Amplifier
* Reference Netlist for Qwen-Based Constrained Sizing
*
* Fixed topology:
*   M1/M2 : NMOS differential pair
*   M3/M4 : PMOS current-mirror active load
*   M5    : NMOS tail current source
*   M6    : NMOS second-stage common-source device
*   M7    : PMOS second-stage current-source load
*
* Process : SKY130
* Corner  : TT
* VDD     : 1.8 V
* ============================================================

.lib "/home/xu/eda/sky130-sim/libs.tech/ngspice/sky130.lib.spice" tt

.temp 27

* ============================================================
* Fixed simulation conditions
* ============================================================

.param VDD=1.8
.param VCM=0.9
.param CLOAD=2p

* ============================================================
* OPTIMIZABLE PARAMETERS
*
* Matching is enforced structurally by shared parameters.
*
* M1 = M2
* L_M3 = L_M4; W_M4 = W_M3
*
* Qwen must modify these parameters only.
* ============================================================

* Differential input pair: M1 = M2
.param W_IN=10
.param L_IN=0.5

* PMOS current mirror: L_M3 = L_M4 = L_LOAD; W_M4 = W_M3 = W_LOAD
.param W_LOAD=10
.param L_LOAD=0.5

* Tail current source: M5

* Second-stage NMOS: M6
.param W_STAGE2=30
.param L_STAGE2=0.5

* Second-stage PMOS load: M7

* Bias reference devices
.param WBN0=10
.param L_BIAS_N=1.0

.param WBP0=10
.param L_BIAS_P=1.0

* Reference bias current
.param IBIAS=20u

* Miller compensation
.param CC=1p

* HARD STRUCTURAL MATCHING: ratios must be positive integers.
* M1/M2: identical W_IN and L_IN.
* M3/M4: shared L_LOAD and W_LOAD, M3 diode-connected.
* MBIAS_N/M5: shared L_BIAS_N; W5=N_TAIL*WBN0.
* MBIAS_P/M7: shared L_BIAS_P; W7=N_STAGE2_LOAD*WBP0.
* Python rejects fractional N and effective device widths outside target bounds.
.param N_TAIL=1
.param N_STAGE2_LOAD=1

* ============================================================
* Supply
* ============================================================

VSUPPLY vdd 0 {VDD}

* ============================================================
* Differential AC input
*
* Common-mode = 0.9 V
* Differential AC amplitude = 1 V
* ============================================================

VINP vinp 0 DC {VCM} AC 0.5
VINN vinn 0 DC {VCM} AC -0.5

* ============================================================
* NMOS bias generation
* ============================================================

IBIAS_N vdd vbias_n {IBIAS}

XMBIAS_N vbias_n vbias_n 0 0 sky130_fd_pr__nfet_01v8
+ W={WBN0} L={L_BIAS_N}

* ============================================================
* First Stage
* ============================================================

* Matched NMOS differential pair

XM1 n1 vinp ntail 0 sky130_fd_pr__nfet_01v8
+ W={W_IN} L={L_IN}

XM2 n2 vinn ntail 0 sky130_fd_pr__nfet_01v8
+ W={W_IN} L={L_IN}

* Matched PMOS current mirror active load

XM3 n1 n1 vdd vdd sky130_fd_pr__pfet_01v8
+ W={W_LOAD} L={L_LOAD}

XM4 n2 n1 vdd vdd sky130_fd_pr__pfet_01v8
+ W={W_LOAD} L={L_LOAD}

* Tail current source

XM5 ntail vbias_n 0 0 sky130_fd_pr__nfet_01v8
+ W={N_TAIL*WBN0} L={L_BIAS_N}

* ============================================================
* PMOS bias generation for second-stage load
* ============================================================

IBIAS_P vbias_p 0 {IBIAS}

XMBIAS_P vbias_p vbias_p vdd vdd sky130_fd_pr__pfet_01v8
+ W={WBP0} L={L_BIAS_P}

* ============================================================
* Second Stage
* ============================================================

* NMOS common-source gain device

XM6 out n2 0 0 sky130_fd_pr__nfet_01v8
+ W={W_STAGE2} L={L_STAGE2}

* PMOS current-source load

XM7 out vbias_p vdd vdd sky130_fd_pr__pfet_01v8
+ W={N_STAGE2_LOAD*WBP0} L={L_BIAS_P}

* ============================================================
* Frequency Compensation
* ============================================================

CCOMP n2 out {CC}

* ============================================================
* Output Load
* ============================================================

CLOAD_OUT out 0 {CLOAD}

* DC-first testbench. Runner removes the marked AC block for DC-only checks.
* Output is inverting relative to VINP-VINN; use -V(out) for loop phase.
.control
set noaskquit
set numdgt=10
op
echo DC_OPERATING_POINT
print v(vdd) v(vinp) v(vinn) v(vbias_n) v(vbias_p)
print v(ntail) v(n1) v(n2) v(out) i(VSUPPLY)
let supply_current_a = -i(VSUPPLY)
let power_w = -i(VSUPPLY)*v(vdd)
print supply_current_a power_w
echo DEVICE_xm1
print @m.xm1.msky130_fd_pr__nfet_01v8[id]
print @m.xm1.msky130_fd_pr__nfet_01v8[gm]
print @m.xm1.msky130_fd_pr__nfet_01v8[gds]
print @m.xm1.msky130_fd_pr__nfet_01v8[vgs]
print @m.xm1.msky130_fd_pr__nfet_01v8[vds]
print @m.xm1.msky130_fd_pr__nfet_01v8[vth]
print @m.xm1.msky130_fd_pr__nfet_01v8[vdsat]
echo DEVICE_xm2
print @m.xm2.msky130_fd_pr__nfet_01v8[id]
print @m.xm2.msky130_fd_pr__nfet_01v8[gm]
print @m.xm2.msky130_fd_pr__nfet_01v8[gds]
print @m.xm2.msky130_fd_pr__nfet_01v8[vgs]
print @m.xm2.msky130_fd_pr__nfet_01v8[vds]
print @m.xm2.msky130_fd_pr__nfet_01v8[vth]
print @m.xm2.msky130_fd_pr__nfet_01v8[vdsat]
echo DEVICE_xm3
print @m.xm3.msky130_fd_pr__pfet_01v8[id]
print @m.xm3.msky130_fd_pr__pfet_01v8[gm]
print @m.xm3.msky130_fd_pr__pfet_01v8[gds]
print @m.xm3.msky130_fd_pr__pfet_01v8[vgs]
print @m.xm3.msky130_fd_pr__pfet_01v8[vds]
print @m.xm3.msky130_fd_pr__pfet_01v8[vth]
print @m.xm3.msky130_fd_pr__pfet_01v8[vdsat]
echo DEVICE_xm4
print @m.xm4.msky130_fd_pr__pfet_01v8[id]
print @m.xm4.msky130_fd_pr__pfet_01v8[gm]
print @m.xm4.msky130_fd_pr__pfet_01v8[gds]
print @m.xm4.msky130_fd_pr__pfet_01v8[vgs]
print @m.xm4.msky130_fd_pr__pfet_01v8[vds]
print @m.xm4.msky130_fd_pr__pfet_01v8[vth]
print @m.xm4.msky130_fd_pr__pfet_01v8[vdsat]
echo DEVICE_xm5
print @m.xm5.msky130_fd_pr__nfet_01v8[id]
print @m.xm5.msky130_fd_pr__nfet_01v8[gm]
print @m.xm5.msky130_fd_pr__nfet_01v8[gds]
print @m.xm5.msky130_fd_pr__nfet_01v8[vgs]
print @m.xm5.msky130_fd_pr__nfet_01v8[vds]
print @m.xm5.msky130_fd_pr__nfet_01v8[vth]
print @m.xm5.msky130_fd_pr__nfet_01v8[vdsat]
echo DEVICE_xm6
print @m.xm6.msky130_fd_pr__nfet_01v8[id]
print @m.xm6.msky130_fd_pr__nfet_01v8[gm]
print @m.xm6.msky130_fd_pr__nfet_01v8[gds]
print @m.xm6.msky130_fd_pr__nfet_01v8[vgs]
print @m.xm6.msky130_fd_pr__nfet_01v8[vds]
print @m.xm6.msky130_fd_pr__nfet_01v8[vth]
print @m.xm6.msky130_fd_pr__nfet_01v8[vdsat]
echo DEVICE_xm7
print @m.xm7.msky130_fd_pr__pfet_01v8[id]
print @m.xm7.msky130_fd_pr__pfet_01v8[gm]
print @m.xm7.msky130_fd_pr__pfet_01v8[gds]
print @m.xm7.msky130_fd_pr__pfet_01v8[vgs]
print @m.xm7.msky130_fd_pr__pfet_01v8[vds]
print @m.xm7.msky130_fd_pr__pfet_01v8[vth]
print @m.xm7.msky130_fd_pr__pfet_01v8[vdsat]
echo DEVICE_xmbias_n
print @m.xmbias_n.msky130_fd_pr__nfet_01v8[id]
print @m.xmbias_n.msky130_fd_pr__nfet_01v8[gm]
print @m.xmbias_n.msky130_fd_pr__nfet_01v8[gds]
print @m.xmbias_n.msky130_fd_pr__nfet_01v8[vgs]
print @m.xmbias_n.msky130_fd_pr__nfet_01v8[vds]
print @m.xmbias_n.msky130_fd_pr__nfet_01v8[vth]
print @m.xmbias_n.msky130_fd_pr__nfet_01v8[vdsat]
echo DEVICE_xmbias_p
print @m.xmbias_p.msky130_fd_pr__pfet_01v8[id]
print @m.xmbias_p.msky130_fd_pr__pfet_01v8[gm]
print @m.xmbias_p.msky130_fd_pr__pfet_01v8[gds]
print @m.xmbias_p.msky130_fd_pr__pfet_01v8[vgs]
print @m.xmbias_p.msky130_fd_pr__pfet_01v8[vds]
print @m.xmbias_p.msky130_fd_pr__pfet_01v8[vth]
print @m.xmbias_p.msky130_fd_pr__pfet_01v8[vdsat]
echo END_DC_OPERATING_POINT
* BEGIN_AC_ANALYSIS
ac dec 100 1 1G
let gain = db(v(out))
let loop_phase_deg = 180/PI*cph(-v(out))
meas ac dc_gain_db FIND gain AT=1
meas ac ugb_hz WHEN gain=0 FALL=1
meas ac phase_at_ugb FIND loop_phase_deg WHEN gain=0 FALL=1
let phase_margin_deg = 180+phase_at_ugb
print phase_margin_deg
* END_AC_ANALYSIS
quit
.endc
.end
