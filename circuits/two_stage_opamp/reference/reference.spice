* ============================================================
* SKY130 Two-Stage CMOS Operational Amplifier
* Reference Netlist for Qwen-Based Constrained Sizing
*
* Fixed topology:
*   M1/M2 : NMOS differential pair
*   M3/M4 : PMOS current-mirror active load
*   M5    : NMOS tail current source
*   M6    : NMOS second-stage common-source device
*   M7    : PMOS second-stage current-source load
*
* Process : SKY130
* Corner  : TT
* VDD     : 1.8 V
* ============================================================

.lib "/home/xu/eda/sky130-sim/libs.tech/ngspice/sky130.lib.spice" tt

.temp 27

* ============================================================
* Fixed simulation conditions
* ============================================================

.param VDD=1.8
.param VCM=0.9
.param CLOAD=2p

* ============================================================
* OPTIMIZABLE PARAMETERS
*
* Matching is enforced structurally by shared parameters.
*
* M1 = M2
* M3 = M4
*
* Qwen must modify these parameters only.
* ============================================================

* Differential input pair: M1 = M2
.param W_IN=10
.param L_IN=0.5

* PMOS current mirror: M3 = M4
.param W_LOAD=10
.param L_LOAD=0.5

* Tail current source: M5
.param W_TAIL=10
.param L_TAIL=1.0

* Second-stage NMOS: M6
.param W_STAGE2=30
.param L_STAGE2=0.5

* Second-stage PMOS load: M7
.param W_STAGE2_LOAD=20
.param L_STAGE2_LOAD=0.5

* Bias reference devices
.param W_BIAS_N=10
.param L_BIAS_N=1.0

.param W_BIAS_P=10
.param L_BIAS_P=1.0

* Reference bias current
.param IBIAS=20u

* Miller compensation
.param CC=1p

* ============================================================
* Supply
* ============================================================

VSUPPLY vdd 0 {VDD}

* ============================================================
* Differential AC input
*
* Common-mode = 0.9 V
* Differential AC amplitude = 1 V
* ============================================================

VINP vinp 0 DC {VCM} AC 0.5
VINN vinn 0 DC {VCM} AC -0.5

* ============================================================
* NMOS bias generation
* ============================================================

IBIAS_N vdd vbias_n {IBIAS}

XMBIAS_N vbias_n vbias_n 0 0 sky130_fd_pr__nfet_01v8
+ W={W_BIAS_N} L={L_BIAS_N}

* ============================================================
* First Stage
* ============================================================

* Matched NMOS differential pair

XM1 n1 vinp ntail 0 sky130_fd_pr__nfet_01v8
+ W={W_IN} L={L_IN}

XM2 n2 vinn ntail 0 sky130_fd_pr__nfet_01v8
+ W={W_IN} L={L_IN}

* Matched PMOS current mirror active load

XM3 n1 n1 vdd vdd sky130_fd_pr__pfet_01v8
+ W={W_LOAD} L={L_LOAD}

XM4 n2 n1 vdd vdd sky130_fd_pr__pfet_01v8
+ W={W_LOAD} L={L_LOAD}

* Tail current source

XM5 ntail vbias_n 0 0 sky130_fd_pr__nfet_01v8
+ W={W_TAIL} L={L_TAIL}

* ============================================================
* PMOS bias generation for second-stage load
* ============================================================

IBIAS_P vbias_p 0 {IBIAS}

XMBIAS_P vbias_p vbias_p vdd vdd sky130_fd_pr__pfet_01v8
+ W={W_BIAS_P} L={L_BIAS_P}

* ============================================================
* Second Stage
* ============================================================

* NMOS common-source gain device

XM6 out n2 0 0 sky130_fd_pr__nfet_01v8
+ W={W_STAGE2} L={L_STAGE2}

* PMOS current-source load

XM7 out vbias_p vdd vdd sky130_fd_pr__pfet_01v8
+ W={W_STAGE2_LOAD} L={L_STAGE2_LOAD}

* ============================================================
* Frequency Compensation
* ============================================================

CCOMP n2 out {CC}

* ============================================================
* Output Load
* ============================================================

CLOAD_OUT out 0 {CLOAD}

* Corrected testbench: same devices, parameters and excitation.
* Output is inverting relative to VINP-VINN; use -V(out) for loop phase.
.control
set noaskquit
set numdgt=10
op
echo DC_OPERATING_POINT
print v(vdd) v(vinp) v(vinn) v(vbias_n) v(vbias_p)
print v(ntail) v(n1) v(n2) v(out) i(VSUPPLY)
let supply_current_a = -i(VSUPPLY)
let power_w = -i(VSUPPLY)*v(vdd)
print supply_current_a power_w
echo DEVICE_xm1
print @m.xm1.msky130_fd_pr__nfet_01v8[id]
print @m.xm1.msky130_fd_pr__nfet_01v8[gm]
print @m.xm1.msky130_fd_pr__nfet_01v8[gds]
print @m.xm1.msky130_fd_pr__nfet_01v8[vgs]
print @m.xm1.msky130_fd_pr__nfet_01v8[vds]
print @m.xm1.msky130_fd_pr__nfet_01v8[vth]
print @m.xm1.msky130_fd_pr__nfet_01v8[vdsat]
echo DEVICE_xm2
print @m.xm2.msky130_fd_pr__nfet_01v8[id]
print @m.xm2.msky130_fd_pr__nfet_01v8[gm]
print @m.xm2.msky130_fd_pr__nfet_01v8[gds]
print @m.xm2.msky130_fd_pr__nfet_01v8[vgs]
print @m.xm2.msky130_fd_pr__nfet_01v8[vds]
print @m.xm2.msky130_fd_pr__nfet_01v8[vth]
print @m.xm2.msky130_fd_pr__nfet_01v8[vdsat]
echo DEVICE_xm3
print @m.xm3.msky130_fd_pr__pfet_01v8[id]
print @m.xm3.msky130_fd_pr__pfet_01v8[gm]
print @m.xm3.msky130_fd_pr__pfet_01v8[gds]
print @m.xm3.msky130_fd_pr__pfet_01v8[vgs]
print @m.xm3.msky130_fd_pr__pfet_01v8[vds]
print @m.xm3.msky130_fd_pr__pfet_01v8[vth]
print @m.xm3.msky130_fd_pr__pfet_01v8[vdsat]
echo DEVICE_xm4
print @m.xm4.msky130_fd_pr__pfet_01v8[id]
print @m.xm4.msky130_fd_pr__pfet_01v8[gm]
print @m.xm4.msky130_fd_pr__pfet_01v8[gds]
print @m.xm4.msky130_fd_pr__pfet_01v8[vgs]
print @m.xm4.msky130_fd_pr__pfet_01v8[vds]
print @m.xm4.msky130_fd_pr__pfet_01v8[vth]
print @m.xm4.msky130_fd_pr__pfet_01v8[vdsat]
echo DEVICE_xm5
print @m.xm5.msky130_fd_pr__nfet_01v8[id]
print @m.xm5.msky130_fd_pr__nfet_01v8[gm]
print @m.xm5.msky130_fd_pr__nfet_01v8[gds]
print @m.xm5.msky130_fd_pr__nfet_01v8[vgs]
print @m.xm5.msky130_fd_pr__nfet_01v8[vds]
print @m.xm5.msky130_fd_pr__nfet_01v8[vth]
print @m.xm5.msky130_fd_pr__nfet_01v8[vdsat]
echo DEVICE_xm6
print @m.xm6.msky130_fd_pr__nfet_01v8[id]
print @m.xm6.msky130_fd_pr__nfet_01v8[gm]
print @m.xm6.msky130_fd_pr__nfet_01v8[gds]
print @m.xm6.msky130_fd_pr__nfet_01v8[vgs]
print @m.xm6.msky130_fd_pr__nfet_01v8[vds]
print @m.xm6.msky130_fd_pr__nfet_01v8[vth]
print @m.xm6.msky130_fd_pr__nfet_01v8[vdsat]
echo DEVICE_xm7
print @m.xm7.msky130_fd_pr__pfet_01v8[id]
print @m.xm7.msky130_fd_pr__pfet_01v8[gm]
print @m.xm7.msky130_fd_pr__pfet_01v8[gds]
print @m.xm7.msky130_fd_pr__pfet_01v8[vgs]
print @m.xm7.msky130_fd_pr__pfet_01v8[vds]
print @m.xm7.msky130_fd_pr__pfet_01v8[vth]
print @m.xm7.msky130_fd_pr__pfet_01v8[vdsat]
echo DEVICE_xmbias_n
print @m.xmbias_n.msky130_fd_pr__nfet_01v8[id]
print @m.xmbias_n.msky130_fd_pr__nfet_01v8[gm]
print @m.xmbias_n.msky130_fd_pr__nfet_01v8[gds]
print @m.xmbias_n.msky130_fd_pr__nfet_01v8[vgs]
print @m.xmbias_n.msky130_fd_pr__nfet_01v8[vds]
print @m.xmbias_n.msky130_fd_pr__nfet_01v8[vth]
print @m.xmbias_n.msky130_fd_pr__nfet_01v8[vdsat]
echo DEVICE_xmbias_p
print @m.xmbias_p.msky130_fd_pr__pfet_01v8[id]
print @m.xmbias_p.msky130_fd_pr__pfet_01v8[gm]
print @m.xmbias_p.msky130_fd_pr__pfet_01v8[gds]
print @m.xmbias_p.msky130_fd_pr__pfet_01v8[vgs]
print @m.xmbias_p.msky130_fd_pr__pfet_01v8[vds]
print @m.xmbias_p.msky130_fd_pr__pfet_01v8[vth]
print @m.xmbias_p.msky130_fd_pr__pfet_01v8[vdsat]
echo END_DC_OPERATING_POINT
ac dec 100 1 1G
let gain = db(v(out))
let loop_phase_deg = 180/PI*cph(-v(out))
meas ac dc_gain_db FIND gain AT=1
meas ac ugb_hz WHEN gain=0 FALL=1
meas ac phase_at_ugb FIND loop_phase_deg WHEN gain=0 FALL=1
let phase_margin_deg = 180+phase_at_ugb
print phase_margin_deg
quit
.endc
.end
