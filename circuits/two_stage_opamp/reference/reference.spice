* ============================================================
* SKY130 Two-Stage CMOS Operational Amplifier
* PMOS second gain stage with series R-C Miller compensation
* M1/M2: NMOS differential pair; M3/M4: matched PMOS mirror
* M5: NMOS tail; M6: NMOS bias sink; M7: PMOS gain device
* MBIAS_N: diode-connected NMOS reference
* Process: SKY130; corner: TT; supply: 1.8 V
* ============================================================

* ============================================================
* Hard constraints and model definitions
* ============================================================

* Allowed scalars: W_IN,L_IN,W_LOAD,L_LOAD,W_STAGE2,L_STAGE2,WBN0,L_BIAS_N,
* IBIAS,CC,N_TAIL,N_STAGE2_BIAS,L_RZ,W_RZ. Preserve topology and models.
* MOS base/effective widths 1..100 um; MOS lengths 0.15..2 um.
* IBIAS 1u..100u A; CC 0.1p..10p F; mirror ratios integers 1..20.
* M1/M2 share W_IN,L_IN; M3/M4 share W_LOAD,L_LOAD, fixed 1:1.
* MBIAS_N/M5/M6 share L_BIAS_N; Wref=WBN0; W5=N_TAIL*WBN0;
* W6=N_STAGE2_BIAS*WBN0. Shared expressions cannot be independently edited.
* L_RZ 0.5..100 um; W_RZ 0.5..10 um; RSH_RZ fixed at 100 ohm/square.
* RCOMP uses the fixed expression RSH_RZ*L_RZ/W_RZ (ohm); initial 1000 ohm.
* This is an ideal geometry-parameterized resistor, NOT a SKY130 physical
* resistor model or a calibrated sheet resistance. No layout/parasitics included.
* Fixed VDD=1.8V, VCM=0.9V, CLOAD=2pF, TT, 27C.
* Numeric acceptance, iteration limits and targets are supplied in target.json.
* Measurements use differential A=OUT/(VINP-VINN), loop L=-A, feedback to VINP.
* The testbench below defines the measured quantities.
*

* ============================================================
* TOPOLOGY-SPECIFIC NOTES (this circuit only; ngspice sweeps, SKY130 TT, estimates)
* ============================================================
* [DC] XM7 VSG = XM3 VSG (~1.07 V) regardless of W_STAGE2/L_STAGE2; I(XM7)=I(XM6)=Is forced.
* Rm=[(W_STAGE2/L_STAGE2)/(W_LOAD/L_LOAD)]*(Ia/Is); Ia/Is ~ 0.44*N_TAIL/N_STAGE2_BIAS, independent of IBIAS.
* out near VDD (~1.7 V), XM7 VSD<0.12 V: W/L too LARGE -> reduce it. out near 0 and XM6 fails: too SMALL -> raise it.
* IBIAS, CC, L_RZ, W_RZ, W_IN do not fix DC. Aim out ~0.9 V.
* Balanced W_STAGE2/L_STAGE2 rises with L_STAGE2 (IBIAS 20u): L=0.5 -> W/L 44-52 passes (W~23), 60 fails;
* L=0.7 -> 64 passes, 43 fails low, 86 fails high; L=1.0 -> ~70-90. Fix L_STAGE2 first, then trim W_STAGE2.
* Near balance out moves ~0.1 V per 1 W/L (L=0.5). IBIAS 25u with W 45/L 0.7 passes. Passing DC gives 74-78 dB gain.
* XM1/XM2 are weak/moderate inversion (Vov~20 mV, gm/Id~20): normal; W_IN barely raises gm1.
* [PERF] After DC (W45 L0.7 IBIAS25u CC1p): gain 77.7 dB, UGB 25 MHz, PM 23.6, 133 uW; only PM fails.
* Cause: RCOMP=100*L_RZ/W_RZ was ~1k < 1/gm7 (2.8-3.8k) -> RHP zero. Raising L_RZ and W_RZ together
* (15/2 ... 60/10) kept RCOMP 600-900 ohm and PM stayed 23-33.
* Verified: W_RZ=1, CC=1p: L_RZ 30/50/70/90 -> PM 40/54/65/70. L_RZ=70: CC 0.5p/1p/1.5p/2p -> PM 41/65/80/91,
* UGB 39/29/24/21 MHz; all targets met. So after DC set RCOMP ~5-8k (W_RZ=1, L_RZ 50-80), CC 1-2p.
* CC bound is 10p (not 2p). UGB~gm1/(2*pi*CC). After targets pass, stop/trim, keep PM>=65, UGB>=15 MHz.
* If PM<60 with RCOMP>1/gm7: raise gm7 (N_STAGE2_BIAS and W_STAGE2 together, then retrim out) or raise CC.
* P~1.8*(IBIAS+I(XM5)+I(XM6)); limit 500 uW. gain<60: check A1/A2; UGB<10M: lower CC or raise IBIAS/N_TAIL.
*
* ============================================================
* Process model and temperature
* ============================================================

.lib "/home/xu/eda/sky130-sim/libs.tech/ngspice/sky130.lib.spice" tt
.temp 27

* ============================================================
* Fixed simulation conditions
* ============================================================

.param VDD=1.8
.param VCM=0.9
.param CLOAD=2p

* ============================================================
* Optimizable parameters
* ============================================================

.param W_IN=10
.param L_IN=0.5

* Matched PMOS mirror dimensions
.param W_LOAD=10
.param L_LOAD=0.5

* NMOS bias-reference dimensions
.param WBN0=10
.param L_BIAS_N=1.0

* PMOS second-stage dimensions
.param W_STAGE2=30
.param L_STAGE2=0.5

* Reference bias current
.param IBIAS=20u

* Miller compensation capacitor
.param CC=1p

* Series resistor: fixed sheet value and adjustable geometry
.param RSH_RZ=100
.param L_RZ=10
.param W_RZ=1

* Integer mirror width ratios
.param N_TAIL=1
.param N_STAGE2_BIAS=1

* ============================================================
* Supply
* ============================================================

VSUPPLY vdd 0 {VDD}

* ============================================================
* Differential input sources
* ============================================================

VINP vinp 0 DC {VCM} AC 0.5
VINN vinn 0 DC {VCM} AC -0.5

* ============================================================
* NMOS bias generation
* ============================================================

IBIAS_N vdd vbias_n {IBIAS}
XMBIAS_N vbias_n vbias_n 0 0 sky130_fd_pr__nfet_01v8
+ W={WBN0} L={L_BIAS_N}

* ============================================================
* First stage: matched NMOS input pair
* ============================================================

XM1 n1 vinp ntail 0 sky130_fd_pr__nfet_01v8
+ W={W_IN} L={L_IN}
XM2 n2 vinn ntail 0 sky130_fd_pr__nfet_01v8
+ W={W_IN} L={L_IN}

* First-stage matched PMOS current mirror
XM3 n1 n1 vdd vdd sky130_fd_pr__pfet_01v8
+ W={W_LOAD} L={L_LOAD}
XM4 n2 n1 vdd vdd sky130_fd_pr__pfet_01v8
+ W={W_LOAD} L={L_LOAD}

* Tail current source
XM5 ntail vbias_n 0 0 sky130_fd_pr__nfet_01v8
+ W={N_TAIL*WBN0} L={L_BIAS_N}

* ============================================================
* Second stage
* ============================================================

XM6 out vbias_n 0 0 sky130_fd_pr__nfet_01v8
+ W={N_STAGE2_BIAS*WBN0} L={L_BIAS_N}

* PMOS common-source gain device
XM7 out n2 vdd vdd sky130_fd_pr__pfet_01v8
+ W={W_STAGE2} L={L_STAGE2}

* ============================================================
* Frequency compensation: n2 -- CCOMP -- ncomp -- RCOMP -- out
* ============================================================

CCOMP n2 ncomp {CC}
RCOMP ncomp out {RSH_RZ*L_RZ/W_RZ}

* ============================================================
* Output load
* ============================================================

CLOAD_OUT out 0 {CLOAD}

* ============================================================
* Analysis and operating-point diagnostics
* ============================================================

.control
set noaskquit
set numdgt=10
op
echo DC_OPERATING_POINT
print v(vdd) v(vinp) v(vinn) v(vbias_n)
print v(ntail) v(n1) v(n2) v(ncomp) v(out) i(VSUPPLY)
let supply_current_a = -i(VSUPPLY)
let power_w = -i(VSUPPLY)*v(vdd)
print supply_current_a power_w

echo DEVICE_xm1
print @m.xm1.msky130_fd_pr__nfet_01v8[id]
print @m.xm1.msky130_fd_pr__nfet_01v8[gm]
print @m.xm1.msky130_fd_pr__nfet_01v8[gds]
print @m.xm1.msky130_fd_pr__nfet_01v8[vgs]
print @m.xm1.msky130_fd_pr__nfet_01v8[vds]
print @m.xm1.msky130_fd_pr__nfet_01v8[vth]
print @m.xm1.msky130_fd_pr__nfet_01v8[vdsat]

echo DEVICE_xm2
print @m.xm2.msky130_fd_pr__nfet_01v8[id]
print @m.xm2.msky130_fd_pr__nfet_01v8[gm]
print @m.xm2.msky130_fd_pr__nfet_01v8[gds]
print @m.xm2.msky130_fd_pr__nfet_01v8[vgs]
print @m.xm2.msky130_fd_pr__nfet_01v8[vds]
print @m.xm2.msky130_fd_pr__nfet_01v8[vth]
print @m.xm2.msky130_fd_pr__nfet_01v8[vdsat]

echo DEVICE_xm3
print @m.xm3.msky130_fd_pr__pfet_01v8[id]
print @m.xm3.msky130_fd_pr__pfet_01v8[gm]
print @m.xm3.msky130_fd_pr__pfet_01v8[gds]
print @m.xm3.msky130_fd_pr__pfet_01v8[vgs]
print @m.xm3.msky130_fd_pr__pfet_01v8[vds]
print @m.xm3.msky130_fd_pr__pfet_01v8[vth]
print @m.xm3.msky130_fd_pr__pfet_01v8[vdsat]

echo DEVICE_xm4
print @m.xm4.msky130_fd_pr__pfet_01v8[id]
print @m.xm4.msky130_fd_pr__pfet_01v8[gm]
print @m.xm4.msky130_fd_pr__pfet_01v8[gds]
print @m.xm4.msky130_fd_pr__pfet_01v8[vgs]
print @m.xm4.msky130_fd_pr__pfet_01v8[vds]
print @m.xm4.msky130_fd_pr__pfet_01v8[vth]
print @m.xm4.msky130_fd_pr__pfet_01v8[vdsat]

echo DEVICE_xm5
print @m.xm5.msky130_fd_pr__nfet_01v8[id]
print @m.xm5.msky130_fd_pr__nfet_01v8[gm]
print @m.xm5.msky130_fd_pr__nfet_01v8[gds]
print @m.xm5.msky130_fd_pr__nfet_01v8[vgs]
print @m.xm5.msky130_fd_pr__nfet_01v8[vds]
print @m.xm5.msky130_fd_pr__nfet_01v8[vth]
print @m.xm5.msky130_fd_pr__nfet_01v8[vdsat]

echo DEVICE_xm6
print @m.xm6.msky130_fd_pr__nfet_01v8[id]
print @m.xm6.msky130_fd_pr__nfet_01v8[gm]
print @m.xm6.msky130_fd_pr__nfet_01v8[gds]
print @m.xm6.msky130_fd_pr__nfet_01v8[vgs]
print @m.xm6.msky130_fd_pr__nfet_01v8[vds]
print @m.xm6.msky130_fd_pr__nfet_01v8[vth]
print @m.xm6.msky130_fd_pr__nfet_01v8[vdsat]

echo DEVICE_xm7
print @m.xm7.msky130_fd_pr__pfet_01v8[id]
print @m.xm7.msky130_fd_pr__pfet_01v8[gm]
print @m.xm7.msky130_fd_pr__pfet_01v8[gds]
print @m.xm7.msky130_fd_pr__pfet_01v8[vgs]
print @m.xm7.msky130_fd_pr__pfet_01v8[vds]
print @m.xm7.msky130_fd_pr__pfet_01v8[vth]
print @m.xm7.msky130_fd_pr__pfet_01v8[vdsat]

echo DEVICE_xmbias_n
print @m.xmbias_n.msky130_fd_pr__nfet_01v8[id]
print @m.xmbias_n.msky130_fd_pr__nfet_01v8[gm]
print @m.xmbias_n.msky130_fd_pr__nfet_01v8[gds]
print @m.xmbias_n.msky130_fd_pr__nfet_01v8[vgs]
print @m.xmbias_n.msky130_fd_pr__nfet_01v8[vds]
print @m.xmbias_n.msky130_fd_pr__nfet_01v8[vth]
print @m.xmbias_n.msky130_fd_pr__nfet_01v8[vdsat]
echo END_DC_OPERATING_POINT

* ============================================================
* AC measurements
* ============================================================

* BEGIN_AC_ANALYSIS
ac dec 100 1 1G
let differential_input = v(vinp)-v(vinn)
let differential_gain = v(out)/differential_input
let loop_gain = -differential_gain
let gain = db(differential_gain)
let loop_phase_deg = 180/PI*cph(loop_gain)
let loop_real = real(loop_gain)
meas ac loop_real_lf FIND loop_real AT=1
meas ac dc_gain_db FIND gain AT=1
meas ac ugb_hz WHEN gain=0 FALL=1
meas ac phase_at_ugb FIND loop_phase_deg WHEN gain=0 FALL=1
let phase_margin_deg = 180+phase_at_ugb
print phase_margin_deg
* END_AC_ANALYSIS

* ============================================================
* End of analysis
* ============================================================

quit
.endc
.end
