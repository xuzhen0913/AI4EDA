* SKY130 Two-Stage Miller Op-Amp, PMOS input / NMOS second stage
* @profile-begin
* TOPOLOGY: two-stage Miller op-amp, PMOS input pair, NMOS common-source second stage.
* FAMILY: two-stage, series R-C Miller compensation. 8 transistors, 1 bias current source, no ideal bias voltages.
* STRUCTURE: PMOS differential pair (tail from VDD) with NMOS current-mirror load (first stage, output n2) ->
* NMOS common-source gain device driven from n2, loaded by a PMOS current source (second stage, output out).
* Miller capacitor CC in series with a resistor from n2 to out. One diode-connected PMOS reference carrying
* IBIAS mirrors to the tail source and the second-stage load through integer ratios (N_TAIL, N_STAGE2_BIAS).
* ADVANTAGES
* - Same two-stage gain mechanism as its NMOS-input counterpart: A0 ~ A1*A2, 60-80 dB reachable without
*   stacking cascodes at 1.8 V; near rail-to-rail output swing; one bias current parameter.
* - The NMOS second-stage device has high gm per current, which pushes the second pole (gm2/CL) up and helps
*   phase margin and the compensation budget.
* - PMOS input pair: input common-mode range extends down to ground and the pair has lower flicker noise
*   than an NMOS pair of equal size -- useful when the input
*   common mode sits low or noise matters.
* - Compensation is explicit and tunable (CC, series resistor).
* DISADVANTAGES
* - PMOS input pair has lower mobility, hence lower gm per current and lower UGB (gm1/(2*pi*CC)) than the
*   NMOS-input version at equal power; reaching a given UGB costs more tail current or a smaller CC.
* - NOT yet verified by simulation in this library: initial sizes are illustrative (baseline simulation: 7 of 8 devices fail
*   the DC gate, output ~1.78 V, and the AC gain is far below 60 dB); expect the same output-node current-matching issue as the
*   other two-stage reference and compensation tuning before the specs are met.
* - Needs frequency compensation; PM is sensitive to the series-resistor value versus 1/gm of the gain device.
* - Power is spent in two stages; weaker supply rejection than cascoded single stages.
* BEST WHEN: gain >= ~60 dB at 1.8 V with wide output swing is needed AND the input common mode is low (near
* ground) or low input noise is valued over raw UGB per mW.
* AVOID WHEN: the input common mode is high, or UGB per mW is the dominant requirement (prefer an NMOS-input
* structure), or an already verified starting point is preferred over an unverified one.
* @profile-end
* @analyses-begin
* [
*  {"type": "current_balance", "gain_device": "XM7", "bias_device": "XM6", "mirror_reference_device": "XM3"},
*  {"type": "miller_compensation", "input_device": "XM1", "first_stage_load_device": "XM3", "gain_device": "XM7", "bias_device": "XM6", "capacitor_parameter": "CC", "series_resistor_expression": "RSH_RZ*L_RZ/W_RZ", "load_capacitance_condition": "load_capacitance_f"}
* ]
* @analyses-end
*
* NOTES (this circuit only; estimates unless marked verified)
* Derived by polarity symmetry from the NMOS-input two-stage reference; NOT verified by simulation.
* Roles: XM3 = diode mirror reference (NMOS), XM4 = mirror output, XM7 = NMOS second-stage gain device,
* XM6 = PMOS second-stage current source, XM5 = PMOS tail source, XMBIAS_P = PMOS diode reference carrying IBIAS.
* Ia = I(XM3) = Itail/2; Is = I(XM6).
* [DC] With equal inputs and XM4 saturated, V(n2) ~ V(n1), so VGS(XM7) ~ VGS(XM3): set by Ia and (W/L)3 only.
* With out unloaded KCL forces I(XM7) = I(XM6) = Is. Capability current of XM7 ~ Ia*[(W/L)7/(W/L)3];
* Rm = [(W/L)7/(W/L)3]*(Ia/Is). Rm > 1: out is pushed to ground and XM7 goes to the triode region;
* Rm < 1: XM6 goes to the triode region (out near VDD). Lowering Rm: reduce (W/L)7, raise N_STAGE2_BIAS,
* reduce N_TAIL, raise (W/L)3. IBIAS scales all currents; Rm is unchanged. Aim out ~ 0.9 V.
* CC, L_RZ, W_RZ, W_IN do not fix DC. The balanced W_STAGE2/L_STAGE2 shifts with L_STAGE2 and with the
* process (NMOS vs PMOS mobility): fix L_STAGE2 first, then trim W_STAGE2 by the measured out voltage.
* [Baseline observed] initial sizes: out ~ 1.78 V (near VDD), DC gate fails; AC gain ~25 dB.
* [GAIN / COMPENSATION] Same relations as any series-R Miller two-stage:
* A0 ~ A1*A2, A1 ~ gm1/(gds1+gds4), A2 ~ gm7/(gds7+gds6); UGB ~ gm1/(2*pi*CC); p2 ~ gm7/CL;
* series R = RSH_RZ*L_RZ/W_RZ; zero s_z = 1/[CC*(1/gm7 - R)] (R < 1/gm7 -> RHP, R > 1/gm7 -> LHP).
* Start with R of a few kohm (W_RZ small, L_RZ large) once DC passes, then trim CC for UGB / PM.
* PMOS gm1 per current is lower than NMOS: expect to need more tail current (N_TAIL, IBIAS) or smaller CC for UGB.
* Power P ~ VDD*(IBIAS + I(XM5) + I(XM6)); limit is in target.json.
*
* Tunable parameters: the .param lines annotated "; tune MIN..MAX [UNIT] [int]" (everything else is fixed).
* Matched PMOS input pair
.param W_IN=10          ; tune 1..100 um
.param L_IN=0.5         ; tune 0.15..2 um

* Matched NMOS mirror load
.param W_LOAD=10        ; tune 1..100 um
.param L_LOAD=0.5       ; tune 0.15..2 um

* PMOS bias reference (tail and second-stage source mirror it)
.param WBP0=10          ; tune 1..100 um
.param L_BIAS_P=1       ; tune 0.15..2 um

* NMOS second-stage gain device
.param W_STAGE2=30      ; tune 1..100 um
.param L_STAGE2=0.5     ; tune 0.15..2 um

* Reference current and Miller capacitor
.param IBIAS=20u        ; tune 1u..100u A
.param CC=1p            ; tune 0.1p..10p F

* Series resistor R = RSH_RZ*L_RZ/W_RZ (ideal geometry resistor)
.param RSH_RZ=100   ; fixed
.param L_RZ=10          ; tune 0.5..100 um
.param W_RZ=1           ; tune 0.5..10 um

* Integer mirror ratios
.param N_TAIL=1         ; tune 1..20 int
.param N_STAGE2_BIAS=1  ; tune 1..20 int

* PMOS diode reference: current sinks from vbias_p to ground.
IBIAS_P vbias_p 0 {IBIAS}
XMBIAS_P vbias_p vbias_p vdd vdd sky130_fd_pr__pfet_01v8
+ W={WBP0} L={L_BIAS_P}
* First stage: PMOS differential input, NMOS mirror load.
XM1 n1 vinp ptail vdd sky130_fd_pr__pfet_01v8
+ W={W_IN} L={L_IN}
XM2 n2 vinn ptail vdd sky130_fd_pr__pfet_01v8
+ W={W_IN} L={L_IN}
XM3 n1 n1 0 0 sky130_fd_pr__nfet_01v8
+ W={W_LOAD} L={L_LOAD}
XM4 n2 n1 0 0 sky130_fd_pr__nfet_01v8
+ W={W_LOAD} L={L_LOAD}
XM5 ptail vbias_p vdd vdd sky130_fd_pr__pfet_01v8
+ W={N_TAIL*WBP0} L={L_BIAS_P}
* Second stage: NMOS common-source with PMOS current-source load.
XM6 out vbias_p vdd vdd sky130_fd_pr__pfet_01v8
+ W={N_STAGE2_BIAS*WBP0} L={L_BIAS_P}
XM7 out n2 0 0 sky130_fd_pr__nfet_01v8
+ W={W_STAGE2} L={L_STAGE2}
CCOMP n2 ncomp {CC}
RCOMP ncomp out {RSH_RZ*L_RZ/W_RZ}
