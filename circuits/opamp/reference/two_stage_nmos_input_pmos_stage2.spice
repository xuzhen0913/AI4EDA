* SKY130 Two-Stage Miller Op-Amp, NMOS input / PMOS second stage
* @profile-begin
* TOPOLOGY: two-stage Miller op-amp, NMOS input pair, PMOS common-source second stage.
* FAMILY: two-stage, series R-C Miller compensation. 8 transistors, 1 bias current source, no ideal bias voltages.
* STRUCTURE: NMOS differential pair with PMOS current-mirror load (first stage, single-ended output n2) ->
* PMOS common-source gain device driven from n2, loaded by an NMOS current sink (second stage, output out).
* Miller capacitor CC in series with a resistor from n2 to out. One diode-connected NMOS reference carrying
* IBIAS mirrors to the tail source and the second-stage sink through integer ratios (N_TAIL, N_STAGE2_BIAS).
* ADVANTAGES
* - Highest DC gain per milliwatt of the library: two cascaded gain stages, A0 ~ A1*A2, no headroom-hungry
*   stacking. 60-80 dB is reachable at L 0.5-1 um with tens of uA per stage at 1.8 V.
* - Near rail-to-rail output swing (one device from each rail at the output); input common-mode range
*   includes mid-supply (VCM = 0.9 V is comfortable) because only the tail source sits under the pair.
* - Needs only ONE bias current parameter; all other currents follow from mirror ratios, so there is no bias
*   voltage to tune and a failed DC point is usually fixed by one W/L and one ratio.
* - Compensation is explicit and tunable (CC, series resistor): phase margin >= 60 deg is reachable by
*   placing the series-resistor zero in the left half plane. A design meeting gain >= 60 dB, UGB >= 10 MHz,
*   PM >= 60 deg and P <= 0.5 mW at 1.8 V / 2 pF has been found with this reference (VERIFIED by simulation).
*   Baseline simulation: only the second-stage gain device fails the DC gate (output ~1.70 V); trimming its W/L fixes it.
* - NMOS input pair gives high gm per unit current (higher electron mobility): good UGB per current.
* DISADVANTAGES
* - Needs frequency compensation; UGB is limited by gm1/(2*pi*CC) and by the second pole ~ gm2/CL, so the
*   achievable UGB at a given power is lower than a single-stage cascode with the same input gm.
* - Phase margin is sensitive to the series-resistor value relative to 1/gm of the gain device (right-half-plane
*   zero when too small); uncompensated starting values typically give PM far below 60 deg.
* - The output DC level depends on current matching between the stages (gain-device capability current versus
*   the sink current): the gain-device W/L must be trimmed or the output saturates at a rail. This is the most
*   common reason the initial design fails the DC gate.
* - Power is spent in two stages, and PSRR / supply rejection is weaker than cascoded single stages.
* BEST WHEN: gain >= ~60 dB is required at a low supply, wide output swing or a capacitive load of a few pF is
* driven, UGB is in the 10-50 MHz range and power is a few hundred uW. A safe first choice for these specs.
* AVOID WHEN: very high UGB at very low power is required, or the load must stay unloaded-stable with no
* compensation capacitor, or gain well above ~80 dB is needed (add cascoding instead).
* @profile-end
* @analyses-begin
* [
*  {"type": "current_balance", "gain_device": "XM7", "bias_device": "XM6", "mirror_reference_device": "XM3"},
*  {"type": "miller_compensation", "input_device": "XM1", "first_stage_load_device": "XM3", "gain_device": "XM7", "bias_device": "XM6", "capacitor_parameter": "CC", "series_resistor_expression": "RSH_RZ*L_RZ/W_RZ", "load_capacitance_condition": "load_capacitance_f"}
* ]
* @analyses-end
*
* NOTES (this circuit only; estimates unless marked verified)
* Roles: XM1/XM2 NMOS differential pair; XM3/XM4 matched PMOS mirror (fixed 1:1); XM5 NMOS tail; XM6 NMOS sink of the
* second stage; XM7 PMOS second-stage gain device; XMBIAS_N diode-connected NMOS reference carrying IBIAS.
* RCOMP is an ideal geometry-parameterised resistor (R = RSH_RZ*L_RZ/W_RZ, initial 1000 ohm), NOT a calibrated SKY130
* resistor model. No layout or parasitics are included.
* [DC] XM7 VSG = XM3 VSG (~1.07 V) regardless of W_STAGE2/L_STAGE2; I(XM7)=I(XM6)=Is forced.
* Rm=[(W_STAGE2/L_STAGE2)/(W_LOAD/L_LOAD)]*(Ia/Is); Ia/Is ~ 0.44*N_TAIL/N_STAGE2_BIAS, independent of IBIAS.
* out near VDD (~1.7 V), XM7 VSD<0.12 V: W/L too LARGE -> reduce it. out near 0 and XM6 fails: too SMALL -> raise it.
* IBIAS, CC, L_RZ, W_RZ, W_IN do not fix DC. Aim out ~0.9 V.
* Balanced W_STAGE2/L_STAGE2 rises with L_STAGE2 (IBIAS 20u): L=0.5 -> W/L 44-52 passes (W~23), 60 fails;
* L=0.7 -> 64 passes, 43 fails low, 86 fails high; L=1.0 -> ~70-90. Fix L_STAGE2 first, then trim W_STAGE2.
* Near balance out moves ~0.1 V per 1 W/L (L=0.5). IBIAS 25u with W 45/L 0.7 passes. Passing DC gives 74-78 dB gain.
* XM1/XM2 are weak/moderate inversion (Vov~20 mV, gm/Id~20): normal; W_IN barely raises gm1.
* [PERF] After DC (W45 L0.7 IBIAS25u CC1p): gain 77.7 dB, UGB 25 MHz, PM 23.6, 133 uW; only PM fails.
* Cause: RCOMP=100*L_RZ/W_RZ was ~1k < 1/gm7 (2.8-3.8k) -> RHP zero. Raising L_RZ and W_RZ together
* (15/2 ... 60/10) kept RCOMP 600-900 ohm and PM stayed 23-33.
* Verified: W_RZ=1, CC=1p: L_RZ 30/50/70/90 -> PM 40/54/65/70. L_RZ=70: CC 0.5p/1p/1.5p/2p -> PM 41/65/80/91,
* UGB 39/29/24/21 MHz; all targets met. So after DC set RCOMP ~5-8k (W_RZ=1, L_RZ 50-80), CC 1-2p.
* UGB~gm1/(2*pi*CC). After targets pass, stop/trim, keep PM>=65, UGB>=15 MHz.
* If PM<60 with RCOMP>1/gm7: raise gm7 (N_STAGE2_BIAS and W_STAGE2 together, then retrim out) or raise CC.
* P~1.8*(IBIAS+I(XM5)+I(XM6)); limit 500 uW. gain<60: check A1/A2; UGB<10M: lower CC or raise IBIAS/N_TAIL.
* [GENERAL RELATIONS FOR THIS STRUCTURE]
* Ia = I(XM3) = Itail/2; Is = I(XM6). F1: with equal inputs and XM4 saturated, V(n2) ~ V(n1), so |VSG(XM7)| ~ |VSG(XM3)|:
* set by Ia and (W/L)3 only, independent of (W/L)7. F2: with out unloaded, KCL forces I(XM7) = I(XM6) = Is; XM7's capability
* current is Ia*[(W/L)7/(W/L)3]; Rm above is their ratio. Rm > 1: out is pushed to VDD and XM7 goes to the triode region.
* Rm < 1: XM6 goes to the triode region. Lowering Rm: reduce (W/L)7, raise N_STAGE2_BIAS, reduce N_TAIL, raise (W/L)3
* (keep XM3/XM4 identical). IBIAS scales all currents together, so Rm is unchanged; it only changes power. After DC passes,
* changing (W/L)7, (W/L)3, N_TAIL, N_STAGE2_BIAS or IBIAS moves Rm and may re-fail DC.
* A0 ~ A1*A2; A1 ~ gm1/(gds1+gds4); A2 ~ gm7/(gds7+gds6). Larger L at the same current raises gm/gds.
* CC does not affect DC gain. Raising CC lowers UGB and the RHP zero gm7/CC and raises p2.
* p2 ~ gm7*CC/(C1*C2+C1*CC+C2*CC) ~ gm7/CL. Raising p2 requires raising gm7 (with N_STAGE2_BIAS and re-trimming Rm), not CC.
* Series resistor zero s_z = 1/[CC*(1/gm7 - R)]: R < 1/gm7 -> RHP, R > 1/gm7 -> LHP. Cancelling p2 needs R ~ 1/gm7 + 1/(CC*omega_p2).
* Scaling L_RZ and W_RZ together leaves R unchanged.
* PM ~ 90 - atan(wu/wp2) - atan(wu/wz_RHP) + atan(wu/wz_LHP) - atan(wu/wp3); an RHP zero near UGB costs 30-45 deg.
*
* Tunable parameters: the .param lines annotated "; tune MIN..MAX [UNIT] [int]" (everything else is fixed).
* Matched NMOS input pair
.param W_IN=10          ; tune 1..100 um
.param L_IN=0.5         ; tune 0.15..2 um

* Matched PMOS mirror load
.param W_LOAD=10        ; tune 1..100 um
.param L_LOAD=0.5       ; tune 0.15..2 um

* NMOS bias reference (tail and second-stage sink mirror it)
.param WBN0=10          ; tune 1..100 um
.param L_BIAS_N=1.0     ; tune 0.15..2 um

* PMOS second-stage gain device
.param W_STAGE2=30      ; tune 1..100 um
.param L_STAGE2=0.5     ; tune 0.15..2 um

* Reference current and Miller capacitor
.param IBIAS=20u        ; tune 1u..100u A
.param CC=1p            ; tune 0.1p..10p F

* Series resistor R = RSH_RZ*L_RZ/W_RZ (ideal geometry resistor)
.param RSH_RZ=100   ; fixed
.param L_RZ=10          ; tune 0.5..100 um
.param W_RZ=1           ; tune 0.5..10 um

* Integer mirror ratios
.param N_TAIL=1         ; tune 1..20 int
.param N_STAGE2_BIAS=1  ; tune 1..20 int

* NMOS bias generation

IBIAS_N vdd vbias_n {IBIAS}
XMBIAS_N vbias_n vbias_n 0 0 sky130_fd_pr__nfet_01v8
+ W={WBN0} L={L_BIAS_N}

* First stage: matched NMOS input pair

XM1 n1 vinp ntail 0 sky130_fd_pr__nfet_01v8
+ W={W_IN} L={L_IN}
XM2 n2 vinn ntail 0 sky130_fd_pr__nfet_01v8
+ W={W_IN} L={L_IN}

* First-stage matched PMOS current mirror
XM3 n1 n1 vdd vdd sky130_fd_pr__pfet_01v8
+ W={W_LOAD} L={L_LOAD}
XM4 n2 n1 vdd vdd sky130_fd_pr__pfet_01v8
+ W={W_LOAD} L={L_LOAD}

* Tail current source
XM5 ntail vbias_n 0 0 sky130_fd_pr__nfet_01v8
+ W={N_TAIL*WBN0} L={L_BIAS_N}

* Second stage

XM6 out vbias_n 0 0 sky130_fd_pr__nfet_01v8
+ W={N_STAGE2_BIAS*WBN0} L={L_BIAS_N}

* PMOS common-source gain device
XM7 out n2 vdd vdd sky130_fd_pr__pfet_01v8
+ W={W_STAGE2} L={L_STAGE2}

* Frequency compensation: n2 -- CCOMP -- ncomp -- RCOMP -- out

CCOMP n2 ncomp {CC}
RCOMP ncomp out {RSH_RZ*L_RZ/W_RZ}
