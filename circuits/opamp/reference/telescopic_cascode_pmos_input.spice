* SKY130 Telescopic-Cascode Op-Amp, PMOS input, single-ended output
* @profile-begin
* TOPOLOGY: telescopic-cascode op-amp, PMOS input pair, single-ended output.
* FAMILY: single-stage cascode (self-compensated by the load capacitor). 9 transistors, ideal bias voltages
* VBP_TAIL, VBP_CAS, VBN_CAS as sizing parameters; no bias current source.
* STRUCTURE: one vertical stack per branch from VDD: PMOS tail -> PMOS input pair -> PMOS cascode -> NMOS
* cascoded-mirror load (diode-connected NMOS mirror pair above a biased NMOS device at ground).
* ADVANTAGES
* - All current is signal current (no fold branch): good gm per current, low power and low noise; 9 devices and only
*   3 bias voltages.
* - High output resistance from the cascode stacks; self-compensated by CL with one dominant pole.
* - PMOS input pair: lower flicker noise; input common mode can sit near ground.
* DISADVANTAGES
* - Five devices stacked between VDD and ground: at 1.8 V the headroom is extremely tight, so input common-mode range
*   and output swing are the smallest of the candidates and a valid bias window may not exist at VCM = 0.9 V.
* - PMOS input pair has lower gm per current than NMOS (needs more current for the same UGB).
* - The high-impedance output node makes the DC level very sensitive to mirror balance and bias voltages.
* - Single-stage gain is limited to roughly (gm*ro)^2-class values at best; the textbook estimate at L = 0.15-0.5 um in
*   this process is 50-70 dB (not measured here), so a 60 dB target is only reachable if EVERY device in the cascode stacks stays saturated.
*   Gain collapses abruptly when any stack device leaves saturation (no gradual degradation).
* - NOT verified in this library: initial sizes/biases are illustrative. Baseline simulation: the DC gate fails
*   (all 9 devices; output ~0.37 V, power ~0.1 uW) and the AC gain is only ~36 dB with UGB ~45 kHz.
* BEST WHEN: noise or power dominates, input common mode is low, and the supply is comfortable.
* AVOID WHEN: VDD is 1.8 V with a mid-supply common mode, a reliable DC pass matters, or output swing must be wide.
* @profile-end
* @analyses-begin
* [
*  {"type": "cascode_stage", "input_device": "XM1", "load_capacitance_condition": "load_capacitance_f", "stacks": {"up_from_out": ["XMC2", "XM2"], "down_from_out": ["XML2", "XMN2"]}}
* ]
* @analyses-end
*
* NOTES (this circuit only; estimates unless marked verified)
* Not verified by simulation (polarity mirror of the NMOS-input telescopic). W_CAS/L_CAS size BOTH XMC (PMOS cascodes below the pair)
* and XMN (NMOS biased devices at ground); W_LOAD/L_LOAD size the NMOS diode/mirror pair XML1/XML2; XMN gates are all at VBN_CAS;
* XMTAIL is set by VBP_TAIL, W_TAIL, L_TAIL.
* Itail = 0.5*kp*(W_TAIL/L_TAIL)*(VDD - VBP_TAIL - |VTp|)^2; each branch carries Itail/2 and the NMOS XMN devices (gate VBN_CAS) must
* be able to pass it: Icap_N = 0.5*kn*(W_CAS/L_CAS)*(VBN_CAS - VTn)^2. If Icap_N < Itail/2, NMOS side starves and out rises toward VDD (or the
* stack sits in a near-zero-current state); if Icap_N >> Itail/2, XMN goes to the triode region and out falls toward ground. Match them first.
* Headroom (VDD = 1.8 V): V(tail) <= VDD - |VDSAT_tail|; V(a) = V(tail) - Vsd_in; XMC gate VBP_CAS ~ V(a) - |Vgs_C|;
* out <= V(a) - |VDSAT_C|; XML diode sits above XMN: V(left) = V(nl) + Vgs_L with V(nl) >= VDSAT_N.
* Input common mode 0.9 V: V(tail) = 0.9 + |Vgs_in|; a larger input overdrive shrinks the room for the tail and cascode.
* Performance: A0 ~ gm1*(Rout_up || Rout_down), UGB ~ gm1/(2*pi*CL), PM normally high. Power ~ VDD*Itail (no fold branch).
*
* Tunable parameters: the .param lines annotated "; tune MIN..MAX [UNIT] [int]" (everything else is fixed).
.param W_IN=20          ; tune 1..100 um
.param L_IN=0.5         ; tune 0.15..2 um
.param W_CAS=12         ; tune 1..100 um
.param L_CAS=0.5        ; tune 0.15..2 um
.param W_LOAD=16        ; tune 1..100 um
.param L_LOAD=0.5       ; tune 0.15..2 um
.param W_TAIL=24        ; tune 1..100 um
.param L_TAIL=1         ; tune 0.15..2 um

* Ideal bias voltages (stand in for a bias generator)
.param VBP_TAIL=1.0     ; tune 0.2..1.6 V
.param VBN_CAS=1.0      ; tune 0.2..1.6 V
.param VBP_CAS=0.8      ; tune 0.2..1.6 V

* Ideal bias voltages
VBPTAIL bp_tail 0 {VBP_TAIL}
VBNCAS bn_cas 0 {VBN_CAS}
VBPCAS bp_cas 0 {VBP_CAS}
* PMOS input pair, tail source and PMOS cascodes
XM1 a vinp tail vdd sky130_fd_pr__pfet_01v8
+ W={W_IN} L={L_IN}
XM2 b vinn tail vdd sky130_fd_pr__pfet_01v8
+ W={W_IN} L={L_IN}
XMTAIL tail bp_tail vdd vdd sky130_fd_pr__pfet_01v8
+ W={W_TAIL} L={L_TAIL}
XMC1 left bp_cas a vdd sky130_fd_pr__pfet_01v8
+ W={W_CAS} L={L_CAS}
XMC2 out bp_cas b vdd sky130_fd_pr__pfet_01v8
+ W={W_CAS} L={L_CAS}
* NMOS mirror load with NMOS devices to ground (output = drain of XMC2/XML2)
XML1 left left nl 0 sky130_fd_pr__nfet_01v8
+ W={W_LOAD} L={L_LOAD}
XML2 out left nr 0 sky130_fd_pr__nfet_01v8
+ W={W_LOAD} L={L_LOAD}
XMN1 nl bn_cas 0 0 sky130_fd_pr__nfet_01v8
+ W={W_CAS} L={L_CAS}
XMN2 nr bn_cas 0 0 sky130_fd_pr__nfet_01v8
+ W={W_CAS} L={L_CAS}
